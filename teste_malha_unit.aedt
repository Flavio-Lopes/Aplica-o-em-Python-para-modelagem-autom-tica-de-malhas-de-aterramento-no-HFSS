# Ansys Electronics Desktop project, version 2024.2
project variables:
  $L = 1.5
  $C = 0.012
  $cond = 0.0005
  $Lz = 0.7
  $R = 6
materials:
  SoloTeste1: permittivity=11.9 conductivity=$cond
  copper: permeability=0.999991 conductivity=58000000
  pec: conductivity=1e+30
  vacuum: permittivity=1

design Malha_unitaria (HFSS, Transient Composite, model units meter)
options: Allow_Material_Override Save_Adaptive_support_files
datasets:
  Lightning8_1: (0, 0) (5e-07, 154) (1e-06, 289.7) (1.5e-06, 408.78) (2e-06, 512.8) (2.5e-06, 603.18) (3e-06, 681.2) (3.5e-06, 748.06) (4e-06, 804.84) (4.5e-06, 852.53) (5e-06, 892.02) (5.5e-06, 924.15) (6e-06, 949.66) (6.5e-06, 969.25) (7e-06, 983.53) (7.5e-06, 993.08) (8e-06, 998.41) (8.5e-06, 1000) (9e-06, 998.27) (9.5e-06, 993.61) (1e-05, 986.38) (1.05e-05, 976.89) (1.1e-05, 965.45) (1.15e-05, 952.3) (1.2e-05, 937.69) (1.25e-05, 921.83) (1.3e-05, 904.92) (1.35e-05, 887.13) (1.4e-05, 868.62) (1.45e-05, 849.54) (1.5e-05, 830) (1.55e-05, 810.12) (1.6e-05, 790) (1.65e-05, 769.74) (1.7e-05, 749.41) (1.75e-05, 729.08) (1.8e-05, 708.82) (1.85e-05, 688.69) (1.9e-05, 668.73) (1.95e-05, 648.98) (2e-05, 629.49) (2.05e-05, 610.28) (2.1e-05, 591.38) (2.15e-05, 572.82) (2.2e-05, 554.61) (2.25e-05, 536.77) (2.3e-05, 519.31) (2.35e-05, 502.24) (2.4e-05, 485.58) (2.45e-05, 469.33) (2.5e-05, 453.48) (2.55e-05, 438.05) (2.6e-05, 423.03) (2.65e-05, 408.43) (2.7e-05, 394.23) (2.75e-05, 380.44) (2.8e-05, 367.06) (2.85e-05, 354.08) (2.9e-05, 341.49) (2.95e-05, 329.28) (3e-05, 317.46) (3.05e-05, 306.01) (3.1e-05, 294.93) (3.15e-05, 284.2) (3.2e-05, 273.83) (3.25e-05, 263.8) (3.3e-05, 254.1) (3.35e-05, 244.73) (3.4e-05, 235.68) (3.45e-05, 226.94) (3.5e-05, 218.5) (3.55e-05, 210.35) (3.6e-05, 202.48) (3.65e-05, 194.89) (3.7e-05, 187.57) (3.75e-05, 180.51) (3.8e-05, 173.7) (3.85e-05, 167.13) (3.9e-05, 160.8) (3.95e-05, 154.7) (4e-05, 148.82) (4.05e-05, 143.15) (4.1e-05, 137.7) (4.15e-05, 132.44) (4.2e-05, 127.37) (4.25e-05, 122.5) (4.3e-05, 117.8) (4.35e-05, 113.28) (4.4e-05, 108.92) (4.45e-05, 104.73) (4.5e-05, 100.7) (4.55e-05, 96.815) (4.6e-05, 93.079) (4.65e-05, 89.483) (4.7e-05, 86.023) (4.75e-05, 82.694) (4.8e-05, 79.491) (4.85e-05, 76.41) (4.9e-05, 73.446) (4.95e-05, 70.595) (5e-05, 67.852)
  Lightning2_5_1: (0, 0) (2e-06, 1000) (4e-06, 999.99) (6e-06, 979.38) (8e-06, 958.76) (1e-05, 938.56) (1.2e-05, 918.79) (1.4e-05, 899.44) (1.6e-05, 880.5) (1.8e-05, 861.95) (2e-05, 843.79) (2.2e-05, 826.02) (2.4e-05, 808.62) (2.6e-05, 791.59) (2.8e-05, 774.92) (3e-05, 758.6) (3.2e-05, 742.62) (3.4e-05, 726.98) (3.6e-05, 711.66) (3.8e-05, 696.67) (4e-05, 682) (4.2e-05, 667.63) (4.4e-05, 653.57) (4.6e-05, 639.81) (4.8e-05, 626.33) (5e-05, 613.14) (5.2e-05, 600.22) (5.4e-05, 587.58) (5.6e-05, 575.2) (5.8e-05, 563.09) (6e-05, 551.23) (6.2e-05, 539.62) (6.4e-05, 528.25) (6.6e-05, 517.13) (6.8e-05, 506.23) (7e-05, 495.57) (7.2e-05, 485.13) (7.4e-05, 474.91) (7.6e-05, 464.91) (7.8e-05, 455.12) (8e-05, 445.53) (8.2e-05, 436.15) (8.4e-05, 426.96) (8.6e-05, 417.97) (8.8e-05, 409.16) (9e-05, 400.55) (9.2e-05, 392.11) (9.4e-05, 383.85) (9.6e-05, 375.77) (9.8e-05, 367.85) (0.0001, 360.1) (0.000102, 352.52) (0.000104, 345.09) (0.000106, 337.82) (0.000108, 330.71) (0.00011, 323.74) (0.000112, 316.92) (0.000114, 310.25) (0.000116, 303.71) (0.000118, 297.32) (0.00012, 291.05) (0.000122, 284.92) (0.000124, 278.92) (0.000126, 273.05) (0.000128, 267.3) (0.00013, 261.67) (0.000132, 256.15) (0.000134, 250.76) (0.000136, 245.48) (0.000138, 240.31) (0.00014, 235.25) (0.000142, 230.29) (0.000144, 225.44) (0.000146, 220.69) (0.000148, 216.04) (0.00015, 211.49) (0.000152, 207.04) (0.000154, 202.68) (0.000156, 198.41) (0.000158, 194.23) (0.00016, 190.14) (0.000162, 186.13) (0.000164, 182.21) (0.000166, 178.37) (0.000168, 174.62) (0.00017, 170.94) (0.000172, 167.34) (0.000174, 163.81) (0.000176, 160.36) (0.000178, 156.99) (0.00018, 153.68) (0.000182, 150.44) (0.000184, 147.27) (0.000186, 144.17) (0.000188, 141.14) (0.00019, 138.16) (0.000192, 135.25) (0.000194, 132.4) (0.000196, 129.61) (0.000198, 126.88) (0.0002, 124.21)
  Lightning1_2_1: (0, 0) (1e-06, 897.45) (2e-06, 1000) (3e-06, 999.81) (4e-06, 986.53) (5e-06, 971.75) (6e-06, 956.98) (7e-06, 942.4) (8e-06, 928.04) (9e-06, 913.9) (1e-05, 899.98) (1.1e-05, 886.26) (1.2e-05, 872.76) (1.3e-05, 859.46) (1.4e-05, 846.36) (1.5e-05, 833.47) (1.6e-05, 820.77) (1.7e-05, 808.26) (1.8e-05, 795.95) (1.9e-05, 783.82) (2e-05, 771.88) (2.1e-05, 760.12) (2.2e-05, 748.53) (2.3e-05, 737.13) (2.4e-05, 725.9) (2.5e-05, 714.84) (2.6e-05, 703.94) (2.7e-05, 693.22) (2.8e-05, 682.66) (2.9e-05, 672.25) (3e-05, 662.01) (3.1e-05, 651.92) (3.2e-05, 641.99) (3.3e-05, 632.21) (3.4e-05, 622.58) (3.5e-05, 613.09) (3.6e-05, 603.75) (3.7e-05, 594.55) (3.8e-05, 585.49) (3.9e-05, 576.57) (4e-05, 567.78) (4.1e-05, 559.13) (4.2e-05, 550.61) (4.3e-05, 542.22) (4.4e-05, 533.96) (4.5e-05, 525.82) (4.6e-05, 517.81) (4.7e-05, 509.92) (4.8e-05, 502.15) (4.9e-05, 494.5) (5e-05, 486.97) (5.1e-05, 479.55) (5.2e-05, 472.24) (5.3e-05, 465.05) (5.4e-05, 457.96) (5.5e-05, 450.98) (5.6e-05, 444.11) (5.7e-05, 437.34) (5.8e-05, 430.68) (5.9e-05, 424.12) (6e-05, 417.65) (6.1e-05, 411.29) (6.2e-05, 405.02) (6.3e-05, 398.85) (6.4e-05, 392.78) (6.5e-05, 386.79) (6.6e-05, 380.9) (6.7e-05, 375.09) (6.8e-05, 369.38) (6.9e-05, 363.75) (7e-05, 358.21) (7.1e-05, 352.75) (7.2e-05, 347.37) (7.3e-05, 342.08) (7.4e-05, 336.87) (7.5e-05, 331.74) (7.6e-05, 326.68) (7.7e-05, 321.7) (7.8e-05, 316.8) (7.9e-05, 311.98) (8e-05, 307.22) (8.1e-05, 302.54) (8.2e-05, 297.93) (8.3e-05, 293.39) (8.4e-05, 288.92) (8.5e-05, 284.52) (8.6e-05, 280.18) (8.7e-05, 275.91) (8.8e-05, 271.71) (8.9e-05, 267.57) (9e-05, 263.49) (9.1e-05, 259.48) (9.2e-05, 255.52) (9.3e-05, 251.63) (9.4e-05, 247.8) (9.5e-05, 244.02) (9.6e-05, 240.3) (9.7e-05, 236.64) (9.8e-05, 233.04) (9.9e-05, 229.49) (0.0001, 225.99)
  Lightning2_6_1: (0, 0) (1e-06, 762.61) (2e-06, 958.43) (3e-06, 1000) (4e-06, 999.73) (5e-06, 988.24) (6e-06, 973.88) (7e-06, 958.9) (8e-06, 943.93) (9e-06, 929.14) (1e-05, 914.56) (1.1e-05, 900.21) (1.2e-05, 886.08) (1.3e-05, 872.17) (1.4e-05, 858.48) (1.5e-05, 845.01) (1.6e-05, 831.75) (1.7e-05, 818.69) (1.8e-05, 805.84) (1.9e-05, 793.19) (2e-05, 780.74) (2.1e-05, 768.49) (2.2e-05, 756.42) (2.3e-05, 744.55) (2.4e-05, 732.86) (2.5e-05, 721.36) (2.6e-05, 710.04) (2.7e-05, 698.89) (2.8e-05, 687.92) (2.9e-05, 677.13) (3e-05, 666.5) (3.1e-05, 656.04) (3.2e-05, 645.74) (3.3e-05, 635.6) (3.4e-05, 625.63) (3.5e-05, 615.81) (3.6e-05, 606.14) (3.7e-05, 596.63) (3.8e-05, 587.26) (3.9e-05, 578.04) (4e-05, 568.97) (4.1e-05, 560.04) (4.2e-05, 551.25) (4.3e-05, 542.6) (4.4e-05, 534.08) (4.5e-05, 525.7) (4.6e-05, 517.45) (4.7e-05, 509.32) (4.8e-05, 501.33) (4.9e-05, 493.46) (5e-05, 485.72) (5.1e-05, 478.09) (5.2e-05, 470.59) (5.3e-05, 463.2) (5.4e-05, 455.93) (5.5e-05, 448.77) (5.6e-05, 441.73) (5.7e-05, 434.8) (5.8e-05, 427.97) (5.9e-05, 421.25) (6e-05, 414.64) (6.1e-05, 408.13) (6.2e-05, 401.73) (6.3e-05, 395.42) (6.4e-05, 389.22) (6.5e-05, 383.11) (6.6e-05, 377.09) (6.7e-05, 371.17) (6.8e-05, 365.35) (6.9e-05, 359.61) (7e-05, 353.97) (7.1e-05, 348.41) (7.2e-05, 342.94) (7.3e-05, 337.56) (7.4e-05, 332.26) (7.5e-05, 327.05) (7.6e-05, 321.91) (7.7e-05, 316.86) (7.8e-05, 311.89) (7.9e-05, 306.99) (8e-05, 302.17) (8.1e-05, 297.43) (8.2e-05, 292.76) (8.3e-05, 288.17) (8.4e-05, 283.64) (8.5e-05, 279.19) (8.6e-05, 274.81) (8.7e-05, 270.5) (8.8e-05, 266.25) (8.9e-05, 262.07) (9e-05, 257.96) (9.1e-05, 253.91) (9.2e-05, 249.92) (9.3e-05, 246) (9.4e-05, 242.14) (9.5e-05, 238.34) (9.6e-05, 234.6) (9.7e-05, 230.92) (9.8e-05, 227.29) (9.9e-05, 223.72) (0.0001, 220.21)
geometry:
  HasteX1 [copper] = polyline((-$L, $L*(2/3), 0meter) ($L, $L*(2/3), 0meter), section circle width=$C)
  HasteY1 [copper] = polyline((-$L*(2/3), -$L, 0meter) (-$L*(2/3), $L, 0meter), section circle width=$C)
  HasteY2 [copper] = polyline(($L*(2/3), -$L, 0meter) ($L*(2/3), $L, 0meter), section circle width=$C)
  Cabo_de_descida [copper] = polyline((0meter, 0meter, 0meter) (0meter, 0meter, 4meter), section circle width=12mm)
  Polyline12 [pec] = polyline((0meter, 0meter, 4meter) (0meter, 0meter, 7meter), section circle width=12mm)
  Polyline13 [vacuum] = polyline((0meter, 0meter, 7meter) (0meter, 0meter, 7.02meter), section rectangle width=12mm height=0meter)
  Sphere1 [SoloTeste1] = sphere(centre=(0meter, 0meter, 60cm), radius=$R)
  coordinate_system plano do solo = origin=(0meter, 0meter, 60cm) Euler Angle ZYZ phi=0deg theta=0deg psi=0deg
  Sphere1.split(plane=XY, keep=NegativeOnly) in plano do solo
  Sphere1_ObjectFromFace1 = object_from(Sphere1.face(at (-4.24264, 0, -3.64264)))
  Box1 [vacuum] = box(corner=(-$R, -$R, -$R), size=(2*$R, 2*$R, $R+6.42)) in plano do solo
  point Point1 = (1meter, 0meter, 0meter) in plano do solo
  point Point2 = (1.5meter, 0meter, 0meter) in plano do solo
  point Point3 = (2meter, 0meter, 0meter) in plano do solo
  point Point4 = (2.5meter, 0meter, 0meter) in plano do solo
  Polyline16 [copper] = polyline((-1meter, 0meter, 0meter) (-1meter, 0meter, 0.5meter), section rectangle width=3mm height=3mm) in plano do solo
  Polyline16.rotate(axis=Z, angle=90deg) in plano do solo
  Polyline16.move(0meter, -1.5meter, 0meter) in plano do solo
  Polyline17 [copper] = polyline((-2meter, 0meter, 0meter) (-2meter, 0meter, 0.5meter), section rectangle width=3mm height=3mm) in plano do solo
  Polyline17.rotate(axis=Z, angle=90deg) in plano do solo
  Polyline17.move(0meter, -1.5meter, 0meter) in plano do solo
  Rectangle2 = rectangle(corner=(-1.9985meter, -0.0015meter, 0.5meter), x_size=(1-0.003) meter, y_size=3mm) in plano do solo
  Rectangle2.rotate(axis=Z, angle=90deg) in plano do solo
  Rectangle2.move(0meter, -1.5meter, 0meter) in plano do solo
  point Point5 = (3meter, 0meter, 0meter) in plano do solo
  Polyline18 [copper] = polyline((-1meter, 0meter, 0meter) (-1meter, 0meter, 0.5meter), section rectangle width=3mm height=3mm) in plano do solo
  Polyline18.rotate(axis=Z, angle=90deg) in plano do solo
  Polyline18.move(0meter, -1.5meter, 0meter) in plano do solo
  Polyline19 [copper] = polyline((-2meter, 0meter, 0meter) (-2meter, 0meter, 0.5meter), section rectangle width=3mm height=3mm) in plano do solo
  Polyline19.rotate(axis=Z, angle=90deg) in plano do solo
  Polyline19.move(0meter, -1.5meter, 0meter) in plano do solo
  Rectangle3 = rectangle(corner=(-1.9985meter, -0.0015meter, 0.5meter), x_size=(1-0.003) meter, y_size=3mm) in plano do solo
  Rectangle3.rotate(axis=Z, angle=90deg) in plano do solo
  Rectangle3.move(0meter, -1.5meter, 0meter) in plano do solo
  [Polyline18, Polyline19, Rectangle3].rotate(axis=Z, angle=-90deg) in plano do solo
  [Polyline18, Polyline19, Rectangle3].move(1.5meter, 0meter, 0meter) in plano do solo
  [Polyline16, Polyline17, Rectangle2].move(0meter, 1meter, 0meter) in plano do solo
  Haste_centra_Y [copper] = polyline((0, -$L, 0meter) (0, $L, 0meter), section circle width=$C)
  Haste_central_X [copper] = polyline((-$L, 0, 0meter) ($L, 0, 0meter), section circle width=$C)
  HasteX2 [copper] = polyline((-$L, -$L*(2/3), 0meter) ($L, -$L*(2/3), 0meter), section circle width=$C)
  list solo = Sphere1.face(at (0, 0, 0.6))
  group Malha = HasteX1, HasteY1, HasteY2, Cabo_de_descida, Haste_centra_Y, Haste_central_X, HasteX2
boundaries and excitations:
  PerfE1_gnd: Perfect E Objects=Sphere1_ObjectFromFace1
  Rad1: Radiation Objects=Box1
  LumpRLC1: Lumped RLC Objects=Rectangle2 CurrentLine{(0, -1.5015, 1.1) -> (0, -2.4985, 1.1)} RLC_Type=Parallel Resistance=10000GOhm
  LumpRLC2: Lumped RLC Objects=Rectangle3 CurrentLine{(-1.002meter, 0meter, 1.1meter) -> (-1.9985, 0, 1.1)} RLC_Type=Parallel Resistance=10000GOhm
  Current1: Current Objects=Polyline13 Direction{(0, 0, 7.02) -> (0, 0, 7)} TimeProfile=Dataset HfssFrequency=1GHz MinFreq=0Hz MaxFreq=400kHz Magnitude=1A Dataset=Lightning1_2_1 DatasetMaxFreq=400kHz
setups:
  Setup1: HfssTransient Frequency=5GHz MaxDeltaE=0.1 MaximumPasses=20 UseImplicitSolver BasisOrder=-1 Transient{ListsForFields=solo UseSaveCount=0 UseSaveStart=1 SaveStart=0s UseSaveDelta=1 SaveDelta=500ns SaveRadFields=0 SaveFDRadFields=0 UseAutoTermination=0 TerminateOnMaximum=1 UseMaxTime=1 MaxTime=100us}
field plots:
  Mag_E_t1: E Field on Setup1 : Transient at Time=8us
reports:
  Transient Plot 1: V(LumpRLC1,Current1), V(LumpRLC2,Current1) vs Time on Setup1 : Transient; markers m1 at 8.7us, m2 at 8.8us
  Calculator Expressions Plot 1: Mag_E_t, Mag_E_t, Mag_E_t, Mag_E_t, Mag_E_t vs Time on Setup1 : Transient; markers m1 at 8.5us, m2 at 8.5us, m3 at 8.5us, m4 at 8.5us, m5 at 8.5us
